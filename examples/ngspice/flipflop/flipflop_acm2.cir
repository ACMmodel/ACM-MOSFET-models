* Positive-edge D flip-flop: transmission-gate master-slave, L = 0.13 um, 500 MHz clock (ACM2, IHP SG13G2 cards, ngspice with OSDI)
.temp 27
.include ../../../cards/ihp_sg13g2/acm2_nmos_point.lib
.include ../../../cards/ihp_sg13g2/acm2_pmos_point.lib

Vdd vdd 0 1.2
Vclk clk 0 pulse(0 1.2 0.5n 50p 50p 0.95n 2n)
Vd d 0 pulse(0 1.2 1.3n 50p 50p 3.9n 8n)
NICn clkb clk 0 0 acm2n_W0p6_L0p13 w=0.6u l=0.13u ad=0.204p as=0.204p pd=1.88u ps=1.88u
NICp clkb clk vdd vdd acm2p_W2_L0p13 w=2u l=0.13u ad=0.68p as=0.68p pd=4.68u ps=4.68u
* master: transparent while clk = 0
NTMn d clkb m1 0 acm2n_W0p6_L0p13 w=0.6u l=0.13u ad=0.204p as=0.204p pd=1.88u ps=1.88u
NTMp d clk m1 vdd acm2p_W0p6_L0p13 w=0.6u l=0.13u ad=0.204p as=0.204p pd=1.88u ps=1.88u
NIM1n m2 m1 0 0 acm2n_W0p6_L0p13 w=0.6u l=0.13u ad=0.204p as=0.204p pd=1.88u ps=1.88u
NIM1p m2 m1 vdd vdd acm2p_W2_L0p13 w=2u l=0.13u ad=0.68p as=0.68p pd=4.68u ps=4.68u
NIM2n m3 m2 0 0 acm2n_W0p6_L0p13 w=0.6u l=0.13u ad=0.204p as=0.204p pd=1.88u ps=1.88u
NIM2p m3 m2 vdd vdd acm2p_W2_L0p13 w=2u l=0.13u ad=0.68p as=0.68p pd=4.68u ps=4.68u
NFMn m3 clk m1 0 acm2n_W0p6_L0p13 w=0.6u l=0.13u ad=0.204p as=0.204p pd=1.88u ps=1.88u
NFMp m3 clkb m1 vdd acm2p_W0p6_L0p13 w=0.6u l=0.13u ad=0.204p as=0.204p pd=1.88u ps=1.88u
* slave: transparent while clk = 1
NTSn m2 clk s1 0 acm2n_W0p6_L0p13 w=0.6u l=0.13u ad=0.204p as=0.204p pd=1.88u ps=1.88u
NTSp m2 clkb s1 vdd acm2p_W0p6_L0p13 w=0.6u l=0.13u ad=0.204p as=0.204p pd=1.88u ps=1.88u
NIS1n q s1 0 0 acm2n_W0p6_L0p13 w=0.6u l=0.13u ad=0.204p as=0.204p pd=1.88u ps=1.88u
NIS1p q s1 vdd vdd acm2p_W2_L0p13 w=2u l=0.13u ad=0.68p as=0.68p pd=4.68u ps=4.68u
NIS2n s3 q 0 0 acm2n_W0p6_L0p13 w=0.6u l=0.13u ad=0.204p as=0.204p pd=1.88u ps=1.88u
NIS2p s3 q vdd vdd acm2p_W2_L0p13 w=2u l=0.13u ad=0.68p as=0.68p pd=4.68u ps=4.68u
NFSn s3 clkb s1 0 acm2n_W0p6_L0p13 w=0.6u l=0.13u ad=0.204p as=0.204p pd=1.88u ps=1.88u
NFSp s3 clk s1 vdd acm2p_W0p6_L0p13 w=0.6u l=0.13u ad=0.204p as=0.204p pd=1.88u ps=1.88u
Cq q 0 5f
.control
pre_osdi ../../../models/acm2.osdi
set noaskquit
set numdgt=8
tran 2p 16n
meas tran q_at_3n find v(q) at=3n
meas tran q_at_7n find v(q) at=7n
meas tran q_at_11n find v(q) at=11n
meas tran q_at_15n find v(q) at=15n
meas tran tcq trig v(clk) val=0.6 rise=2 targ v(q) val=0.6 rise=1
print q_at_3n q_at_7n q_at_11n q_at_15n tcq > flipflop_acm2_results.txt
quit
.endc
.end
